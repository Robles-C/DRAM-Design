** Profile: "SCHEMATIC1-DRAM"  [ c:\cadence\dram-pspicefiles\schematic1\dram.sim ]

** Creating circuit file "DRAM.cir"
** WARNING: THIS AUTOMATICALLY GENERATED FILE MAY BE OVERWRITTEN BY SUBSEQUENT SIMULATIONS

*Libraries:
* Profile Libraries :
* Local Libraries :
.LIB "../../../dram-pspicefiles/dram.lib"
* From [PSPICE NETLIST] section of C:\Users\zg790138\cdssetup\OrCAD_PSpice\22.1.0\PSpice.ini file:
.lib "nom.lib"

*Analysis directives:
.TRAN  0 100us 0
.OPTIONS ADVCONV
.PROBE64 V(alias(*)) I(alias(*)) W(alias(*)) D(alias(*)) NOISE(alias(*))
.INC "..\SCHEMATIC1.net"

.END
